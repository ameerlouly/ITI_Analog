ADE simulation setup
Run mode: Single Run, Sweeps and Corners
Tests:
  ITI_Lab09:Testbench:1: ITI_Lab09/Testbench/schematic, simulator spectre
    Outputs: Current Mirror 2 Region; DC Gain; Diff Gain; CM Gain
Global variables:
  Cc = 2.55p
  CL = 5p
  IB = 10u
  Rc = 13k
  VDD = 1.8
  VICM = 0.6
  W5 = 6.26u
  VID = 1
  VICMAC = 0
  VIDDC = 0
