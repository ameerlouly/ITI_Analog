ADE simulation setup
Run mode: Single Run, Sweeps and Corners
Tests:
  ITI_Lab09:Testbench_cl:1: ITI_Lab09/Testbench_cl/schematic, simulator spectre
Global variables:
  Cc = 2p
  CL = 5p
  IB = 10u
  Rc = 5k
  VDD = 1.8
  VICM = 0.6
  W5 = 6.26u
  VCIM = 0.6
