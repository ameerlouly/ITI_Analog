** sch_path: /home/tare/ITI_Analog/ITI_Labs/Lab11_Xschem/Design/Testbench.sch
**.subckt Testbench
X1 VDD VCTRLP VBP VOUTN VINP VOUTP VINN VBN GND OTA
Xbalun1 net2 net1 VINP VINN balun
V1 VDD GND 2.5
I0 VBP GND 10u
VICM net1 GND 0.5 AC 0
VID net2 GND DC 0 AC 1
C1 VOUTP GND 500f m=1
C2 VOUTN GND 500f m=1
Xbalun2 VOUTDIFF VOUTCM VOUTP VOUTN balun
x2 VDD GND VBN VOUTN VCTRLP VREF VBP VOUTP CMFB_Behav
V2 VREF GND 1.25
* noconn VOUTCM
* noconn VOUTDIFF
**** begin user architecture code

.include sim_script.sim

.include /home/tare/pdk/gf180mcuC/libs.tech/ngspice/design.ngspice
.lib /home/tare/pdk/gf180mcuC/libs.tech/ngspice/sm141064.ngspice typical

**** end user architecture code
**.ends

* expanding   symbol:  OTA.sym # of pins=9
** sym_path: /home/tare/ITI_Analog/ITI_Labs/Lab11_Xschem/Design/OTA.sym
** sch_path: /home/tare/ITI_Analog/ITI_Labs/Lab11_Xschem/Design/OTA.sch
.subckt OTA AVDD VCTRLP IBn VOUTN VINP VOUTP VINN VBN AGND
*.iopin IBn
*.iopin AVDD
*.iopin AGND
*.iopin VINN
*.iopin VINP
*.iopin VOUTN
*.iopin VOUTP
*.iopin VCTRLP
*.iopin VBN
XM2 net4 VINP net5 net5 pmos_3p3 L=500n W=15u nf=1 ad='int((nf+1)/2) * W/nf * 0.18u' as='int((nf+2)/2) * W/nf * 0.18u' pd='2*int((nf+1)/2) * (W/nf + 0.18u)'
+ ps='2*int((nf+2)/2) * (W/nf + 0.18u)' nrd='0.18u / W' nrs='0.18u / W' sa=0 sb=0 sd=0 m=1
XM1 net2 VINN net5 net5 pmos_3p3 L=500n W=15u nf=1 ad='int((nf+1)/2) * W/nf * 0.18u' as='int((nf+2)/2) * W/nf * 0.18u' pd='2*int((nf+1)/2) * (W/nf + 0.18u)'
+ ps='2*int((nf+2)/2) * (W/nf + 0.18u)' nrd='0.18u / W' nrs='0.18u / W' sa=0 sb=0 sd=0 m=1
XM9 net5 VCTRLP AVDD AVDD pmos_3p3 L=1u W=2*9.75u nf=1 ad='int((nf+1)/2) * W/nf * 0.18u' as='int((nf+2)/2) * W/nf * 0.18u' pd='2*int((nf+1)/2) * (W/nf + 0.18u)'
+ ps='2*int((nf+2)/2) * (W/nf + 0.18u)' nrd='0.18u / W' nrs='0.18u / W' sa=0 sb=0 sd=0 m=1
XM6 VOUTP VCASCP net3 AVDD pmos_3p3 L=700n W=15u nf=1 ad='int((nf+1)/2) * W/nf * 0.18u' as='int((nf+2)/2) * W/nf * 0.18u' pd='2*int((nf+1)/2) * (W/nf + 0.18u)'
+ ps='2*int((nf+2)/2) * (W/nf + 0.18u)' nrd='0.18u / W' nrs='0.18u / W' sa=0 sb=0 sd=0 m=1
XM11 net3 VB1 AVDD AVDD pmos_3p3 L=1u W=9.75u nf=1 ad='int((nf+1)/2) * W/nf * 0.18u' as='int((nf+2)/2) * W/nf * 0.18u' pd='2*int((nf+1)/2) * (W/nf + 0.18u)'
+ ps='2*int((nf+2)/2) * (W/nf + 0.18u)' nrd='0.18u / W' nrs='0.18u / W' sa=0 sb=0 sd=0 m=1
XM4 VOUTP VCASCN net4 AGND nmos_3p3 L=500n W=9u nf=1 ad='int((nf+1)/2) * W/nf * 0.18u' as='int((nf+2)/2) * W/nf * 0.18u' pd='2*int((nf+1)/2) * (W/nf + 0.18u)'
+ ps='2*int((nf+2)/2) * (W/nf + 0.18u)' nrd='0.18u / W' nrs='0.18u / W' sa=0 sb=0 sd=0 m=1
XM8 net4 VBN AGND AGND nmos_3p3 L=1u W=5u nf=1 ad='int((nf+1)/2) * W/nf * 0.18u' as='int((nf+2)/2) * W/nf * 0.18u' pd='2*int((nf+1)/2) * (W/nf + 0.18u)'
+ ps='2*int((nf+2)/2) * (W/nf + 0.18u)' nrd='0.18u / W' nrs='0.18u / W' sa=0 sb=0 sd=0 m=1
XM5 VOUTN VCASCP net1 AVDD pmos_3p3 L=700n W=15u nf=1 ad='int((nf+1)/2) * W/nf * 0.18u' as='int((nf+2)/2) * W/nf * 0.18u' pd='2*int((nf+1)/2) * (W/nf + 0.18u)'
+ ps='2*int((nf+2)/2) * (W/nf + 0.18u)' nrd='0.18u / W' nrs='0.18u / W' sa=0 sb=0 sd=0 m=1
XM10 net1 VB1 AVDD AVDD pmos_3p3 L=1u W=9.75u nf=1 ad='int((nf+1)/2) * W/nf * 0.18u' as='int((nf+2)/2) * W/nf * 0.18u' pd='2*int((nf+1)/2) * (W/nf + 0.18u)'
+ ps='2*int((nf+2)/2) * (W/nf + 0.18u)' nrd='0.18u / W' nrs='0.18u / W' sa=0 sb=0 sd=0 m=1
XM3 VOUTN VCASCN net2 AGND nmos_3p3 L=500n W=9u nf=1 ad='int((nf+1)/2) * W/nf * 0.18u' as='int((nf+2)/2) * W/nf * 0.18u' pd='2*int((nf+1)/2) * (W/nf + 0.18u)'
+ ps='2*int((nf+2)/2) * (W/nf + 0.18u)' nrd='0.18u / W' nrs='0.18u / W' sa=0 sb=0 sd=0 m=1
XM7 net2 VBN AGND AGND nmos_3p3 L=1u W=5u nf=1 ad='int((nf+1)/2) * W/nf * 0.18u' as='int((nf+2)/2) * W/nf * 0.18u' pd='2*int((nf+1)/2) * (W/nf + 0.18u)'
+ ps='2*int((nf+2)/2) * (W/nf + 0.18u)' nrd='0.18u / W' nrs='0.18u / W' sa=0 sb=0 sd=0 m=1
XM12 VBN VB1 AVDD AVDD pmos_3p3 L=1u W=2*9.75u nf=1 ad='int((nf+1)/2) * W/nf * 0.18u' as='int((nf+2)/2) * W/nf * 0.18u' pd='2*int((nf+1)/2) * (W/nf + 0.18u)'
+ ps='2*int((nf+2)/2) * (W/nf + 0.18u)' nrd='0.18u / W' nrs='0.18u / W' sa=0 sb=0 sd=0 m=1
XM13 VBN VBN AGND AGND nmos_3p3 L=1u W=5u nf=1 ad='int((nf+1)/2) * W/nf * 0.18u' as='int((nf+2)/2) * W/nf * 0.18u' pd='2*int((nf+1)/2) * (W/nf + 0.18u)'
+ ps='2*int((nf+2)/2) * (W/nf + 0.18u)' nrd='0.18u / W' nrs='0.18u / W' sa=0 sb=0 sd=0 m=1
XM14 VB1 VB1 AVDD AVDD pmos_3p3 L=1u W=2*9.75u nf=1 ad='int((nf+1)/2) * W/nf * 0.18u' as='int((nf+2)/2) * W/nf * 0.18u' pd='2*int((nf+1)/2) * (W/nf + 0.18u)'
+ ps='2*int((nf+2)/2) * (W/nf + 0.18u)' nrd='0.18u / W' nrs='0.18u / W' sa=0 sb=0 sd=0 m=1
XM15 IBn IBn VB1 AVDD pmos_3p3 L=700n W=20u nf=1 ad='int((nf+1)/2) * W/nf * 0.18u' as='int((nf+2)/2) * W/nf * 0.18u' pd='2*int((nf+1)/2) * (W/nf + 0.18u)'
+ ps='2*int((nf+2)/2) * (W/nf + 0.18u)' nrd='0.18u / W' nrs='0.18u / W' sa=0 sb=0 sd=0 m=1
V1 VCASCN AGND 953.1m
V2 VCASCP AGND 1.4515
**** begin user architecture code

**** end user architecture code
.ends

* expanding   symbol:  balun.sym # of pins=4
** sym_path: /home/tare/ITI_Analog/ITI_Labs/Lab11_Xschem/Design/balun.sym
** sch_path: /home/tare/ITI_Analog/ITI_Labs/Lab11_Xschem/Design/balun.sch
.subckt balun d c p n
*.iopin p
*.iopin n
*.iopin d
*.iopin c
E1 net1 c d 0 0.5
V1 p net1 0
F1 d 0 V1 -0.5
R1 d 0 1T m=1
E2 net2 n d 0 0.5
V2 c net3 0
F2 d 0 V2 -0.5
R2 net3 net2 1u m=1
.ends

* expanding   symbol:  CMFB_Behav.sym # of pins=8
** sym_path: /home/tare/ITI_Analog/ITI_Labs/Lab11_Xschem/Design/CMFB_Behav.sym
** sch_path: /home/tare/ITI_Analog/ITI_Labs/Lab11_Xschem/Design/CMFB_Behav.sch
.subckt CMFB_Behav AVDD AGND VBN VOUT1 VCTRLP VREF VBP VOUT2
*.iopin VOUT1
*.iopin VOUT2
*.iopin VREF
*.iopin VCTRLP
*.iopin VBP
*.iopin AVDD
*.iopin AGND
*.iopin VBN
E1 net3 GND VOUT1 GND 1
E2 net1 GND VOUT2 GND 1
E3 VCTRLP VBP net2 VREF 1
R1 net3 net2 50k m=1
R2 net2 net1 50k m=1
* noconn AVDD
* noconn AGND
* noconn VBN
.ends

.GLOBAL VDD
.GLOBAL GND
.end
